ADE simulation setup
Run mode: Single Run, Sweeps and Corners
Tests:
  ClassDMiniProject1_SMPC1_partB_1: ClassDMiniProject1/SMPC1_partB/schematic, simulator spectre
    Variables: C = 6.6n; D = 0.37; L = 10u; RL = 120; deadtime = 10n; fsw = 4M; NmosL = 600n; NmosW = 500u; PmosL = 500n; PmosW = 500u; Von = 3.3; PowerNmosL = 600n; PowerNmosW = 500u; PowerPmosL = 500n; PowerPmosW = 500u
    Outputs: Duty; Ron_Nmos
