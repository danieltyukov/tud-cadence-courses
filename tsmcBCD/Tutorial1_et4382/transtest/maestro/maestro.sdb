ADE simulation setup
Run mode: Single Run, Sweeps and Corners
Tests:
  Tutorial1_et4382:transtest:1: Tutorial1_et4382/transtest/schematic, simulator spectre
    Variables: C = 30n; R = 1k; fin = Xint*fbin; fbin = 250; Xint = 5; fs = fbin*N_fft; N_fft = 2**16
    Outputs: /VOUT; spectrum
