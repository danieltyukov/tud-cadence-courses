ADE simulation setup
Test Tutorial1_et4382:transtest:1: Tutorial1_et4382/transtest/schematic, simulator spectre
  Models: /opt/ei/DK/tsmc/oa180/mini018BCDG2/216A/tsmc18/../models/spectre/c018bcd_gen2_v1d6_usage.scs[pre_simu, tt_lib]
  Variables: C = 30n; R = 1k; fbin = 250; Xint = 5; N_fft = 2**16; fin = Xint*fbin; fs = fbin*N_fft
  Temperature: 27
  Analysis tran: stop=4.2m errpreset=conservative maxstep=0.1/fs
  Output /VOUT = VT("/VOUT")
  Output spectrum = dB20(((dftv "/VOUT" ?result "tran") 0.0002 4 0.002 65536 "Hanning" 1 "default" 1.0))
  Signals: /VIN, /VOUT
Run mode: Single Run, Sweeps and Corners
