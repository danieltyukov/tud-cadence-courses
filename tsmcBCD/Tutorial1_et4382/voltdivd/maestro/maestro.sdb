ADE simulation setup
Run mode: Single Run, Sweeps and Corners
Tests:
  Tutorial1_et4382:voltdivd:1: Tutorial1_et4382/voltdivd/schematic, simulator spectre
