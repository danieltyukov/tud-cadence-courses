ADE simulation setup
Test Tutorial1_et4382:voltdivd:1: Tutorial1_et4382/voltdivd/schematic, simulator spectre
  Models: /opt/ei/DK/tsmc/oa180/mini018BCDG2/216A/tsmc18/../models/spectre/c018bcd_gen2_v1d6_usage.scs[pre_simu, tt_lib]
  Temperature: 27
  Analysis dc: (saves the operating point)
Run mode: Single Run, Sweeps and Corners
