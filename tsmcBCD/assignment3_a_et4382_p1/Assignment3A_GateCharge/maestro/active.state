ADE simulation setup
Test ClassDMiniProject1_Assignment3A_GateCharge_1: ClassDMiniProject1/Assignment3A_GateCharge/schematic, simulator spectre
  Models: /opt/ei/DK/tsmc/muse/BCDG2/2.16B_5M6_40K/tsmc18/../models/spectre/c018bcd_gen2_v1d6_usage.scs[pre_simu, tt_lib]
  Temperature: 150
  Analysis tran: stop=10u errpreset=conservative
  Signals: /R1/PLUS (terminal), /Vg, /Vd
Run mode: Single Run, Sweeps and Corners
