ADE simulation setup
Run mode: Single Run, Sweeps and Corners
Tests:
  ClassDMiniProject1_Assignment3A_GateCharge_1: ClassDMiniProject1/Assignment3A_GateCharge/schematic, simulator spectre
