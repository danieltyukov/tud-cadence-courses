ADE simulation setup
Run mode: Single Run, Sweeps and Corners
Tests:
  a3a_p1_halfbridge_soft_switching: assignment3_a_et4382_p1/output_stage/schematic, simulator spectre
    Outputs: /input; /O+; /O-; /Vgh; /Vgl; /sw; /V3/PLUS; /V3/MINUS; VgsH
