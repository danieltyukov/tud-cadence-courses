ADE simulation setup
Test ClassDMiniProject1_Assignment3A_OutputStage_1
Test a3a_p1_halfbridge_soft_switching: assignment3_a_et4382_p1/output_stage/schematic, simulator spectre
  Models: /opt/ei/DK/tsmc/oa180/mini018BCDG2/216A/tsmc18/../models/spectre/c018bcd_gen2_v1d6_usage.scs[pre_simu, tt_lib]
  Temperature: 150
