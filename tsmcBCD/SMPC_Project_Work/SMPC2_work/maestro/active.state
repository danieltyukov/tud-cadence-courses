ADE simulation setup
Test SMPC_Project_Work_SMPC2_work_1: SMPC_Project_Work/SMPC2_work/schematic, simulator spectre
  Models: /opt/ei/DK/tsmc/muse/BCDG2/2.16B_5M6_40K/tsmc18/../models/spectre/c018bcd_gen2_v1d6_usage.scs[pre_simu, tt_lib]
  Variables: PowerNmosL = 600n; PowerNmosW = 500u; PowerPmosL = 500n; PowerPmosW = 500u; NmosL = 600n; NmosW = 500u; PmosL = 500n; PmosW = 500u; Von = 5; deadtime = 10n; fsw = 2M; C = 1u; D = 0.36; L = 10u; RL = 4
  Temperature: 27
  Analysis tran: stop=320u errpreset=conservative
  Output IL_avg = average(IT("/L0/PLUS")) (unticked)
  Output Duty = VAR("D") (unticked)
  Output VSD_Pmos = (VT("/Vss") - VT("/VPWM")) (unticked)
  Output VDS_Nmos = (VT("/VPWM") - VT("/gnd!")) (unticked)
  Output IL_p2p = peakToPeak(clip(IT("/L0/PLUS") 0.0002 0.0003)) (unticked)
  Output Ron_Pmos = (VSD_Pmos / IT("/M0/D")) (unticked)
  Output Ron_Nmos = (VDS_Nmos / IT("/M1/D")) (unticked)
  Signals: /O+, /O-, /VPWM, /Vout, /net12, /net14, /L0/PLUS (terminal) as Iout, /M0/D (terminal) as Id_Pmos, /M1/D (terminal) as Id_Nmos, /Vss, /gnd!, /R0/PLUS (terminal)
Run mode: Single Run, Sweeps and Corners
Setup values for test SMPC_Project_Work_SMPC2_work_1: C = 6.6n; D = 0.37; RL = 120; fsw = 4M; Von = 3.3
