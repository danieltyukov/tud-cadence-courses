ADE simulation setup
Run mode: Single Run, Sweeps and Corners
Tests:
  SCPC_HW1_A_1: SCPC2025/HW1_A/schematic, simulator spectre
    Variables: CF = 1.33n; COUT = 80n; f = 200M; INITIAL = 0.8; iout = 10m; R = 11.31; tfr = 50p; tnonov = 50p; vin = 4; tstop = 15u; tsettle = 7u; M = 0.25
    Outputs: Rout; (((VAR("M") * VAR("vin")) - value(VT("/VOUT") VAR("tsettle"))) / VAR("iout"))
