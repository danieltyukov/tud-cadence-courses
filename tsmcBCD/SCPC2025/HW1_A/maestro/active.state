ADE simulation setup
Test SCPC_HW1_A_1: SCPC2025/HW1_A/schematic, simulator spectre
  Models: /opt/ei/DK/tsmc/oa180/mini018BCDG2/216A/tsmc18/../models/spectre/c018bcd_gen2_v1d6_usage.scs[pre_simu, tt_lib]
  Variables: CF = 1.33n; COUT = 80n; f = 200M; INITIAL = 0.8; iout = 10m; R = 11.31; tfr = 50p; tnonov = 50p; vin = 4; tstop = 15u; tsettle = 7u; M = 0.25
  Temperature: 27
  Simulator options: reltol=1e-5
  Analysis tran: stop=VAR("tstop") errpreset=conservative
  Output Rout = (((VAR("M") * VAR("vin")) - value(VT("/VOUT") VAR("tsettle"))) / VAR("iout"))
  Signals: /VOUT
Run mode: Single Run, Sweeps and Corners
