ADE simulation setup
Test ClassDMiniProject1_SMPC1_partB_1: ClassDMiniProject1/SMPC1_partB/schematic, simulator spectre
  Models: /opt/ei/DK/tsmc/muse/BCDG2/2.16B_5M6_40K/tsmc18/../models/spectre/c018bcd_gen2_v1d6_usage.scs[pre_simu, tt_lib]
  Variables: deadtime = 10n; fsw = 2M; C = 1u; D = 0.3636; L = 10u; RL = 16
  Temperature: 27
  Analysis tran: stop=320u errpreset=conservative
  Output IL_avg = average(IT("/L0/PLUS"))
  Output Duty = VAR("D")
  Output VSD_Pmos = (VT("/Vss") - VT("/VPWM"))
  Output VDS_Nmos = (VT("/VPWM") - VT("/gnd!"))
  Output IL_p2p = peakToPeak(clip(IT("/L0/PLUS") 0.0002 0.0003))
  Output Ron_Pmos = (VSD_Pmos / IT("/M0/D"))
  Output Ron_Nmos = (VDS_Nmos / IT("/M1/D"))
  Signals: /O+, /O-, /VPWM, /Vout, /net12, /net14, /L0/PLUS (terminal), /M0/D (terminal) as Id_Pmos, /M1/D (terminal) as Id_Nmos, /Vss, /gnd!
Run mode: Single Run, Sweeps and Corners
