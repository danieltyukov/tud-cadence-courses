ADE simulation setup
Run mode: Single Run, Sweeps and Corners
Tests:
  ClassDMiniProject1_SMPC1_partB_1: ClassDMiniProject1/SMPC1_partB/schematic, simulator spectre
    Variables: C = 1u; D = 0.3636; L = 10u; RL = 16; deadtime = 10n; fsw = 2M
    Outputs: Duty; Ron_Nmos
